;--------------------------------
; Program  : virtuoso-utils(ycGetOccTransform.il)
; Language : Cadence Skill
; Author   : YEUNGCHIE
;--------------------------------

procedure(ycGetOccTransform(occ "g")
    dbGetHierPathTransform(occ)
)

; END
