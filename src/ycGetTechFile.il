;--------------------------------
; Program  : virtuoso-utils(ycGetTechFile.il)
; Language : Cadence Skill
; Author   : YEUNGCHIE
;--------------------------------

procedure(ycGetTechFile(\@optional cvId(geGetEditCellView()) "d")
    techGetTechFile(cvId)
)

; END
